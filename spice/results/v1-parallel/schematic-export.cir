.title KiCad schematic
.include "C:/Workspace/amplikt88/spice/amplikt88.lib"
C16 /V2_G2 GND 2.2u
R10 /V2_G2 /LTP_G1 1.8meg
R13 /G3_IN /V3_G1 5k
R14 /G4_IN /V4_G1 5k
R12 /G4_IN /BIAS_B 200k
R11 /G3_IN /BIAS_A 200k
C7 /LTP_A2 /G3_IN 2.2u
C8 /LTP_A1 /G4_IN 2.2u
R19 /V3_K GND 1
XV3 /OT_A1 /G2_V3 /V3_G1 /V3_K KT88
R17 /G2_V3 /OT_UL1 470
XTR2 /OT_A1 /OT_UL1 B_PLUS /OT_UL2 /OT_A2 /OT_S_HI GND OT_PP_UL LH=10 RATIO=22.4
R20 /V4_K GND 1
XV4 /OT_A2 /G2_V4 /V4_G1 /V4_K KT88
R18 /G2_V4 /OT_UL2 470
XV2 /LTP_A1 /LTP_G1 /LTP_K /LTP_A2 /V2_G2 /LTP_K ECC83
XV1 /V1_A /V1_G /V1_K /LTP_K /CCS_G Net-_V1A-K_ ECC83
R31 Net-_V1A-K_ BIAS_CCS 13k
R33 /CCS_G BIAS_CCS 392k
R1 /IN_C /V1_G 1k
R2 /IN_C GND 470k
C17 /LAG_STEP GND 180p
R29 /V1_A /LAG_STEP 15k
C3 /IN_RAW /IN_C 100n
R28 /BIAS_B VBIAS_NEG 220k
XRV1 VBIAS_NEG /BIAS_A /BA_LO POT_TRIM R=10k POS=0.5
R27 /BIAS_A VBIAS_NEG 220k
C10 /BIAS_B GND 1u
C9 /BIAS_A GND 1u
R15 /BA_LO GND 27k
XRV2 VBIAS_NEG /BIAS_B /BB_LO POT_TRIM R=10k POS=0.5
R16 /BB_LO GND 27k
R3 B_V1 /V1_A 470k
R5 /V1_A /LTP_G1 1k
R4 /V1_K GND 1.5k
R6 B_DRV /LTP_A1 100k
R7 B_DRV /LTP_A2 100k
R32 /CCS_G GND 604k
C18 GND /CCS_G 10u
C6 /V1_K /OT_S_HI 12p
R9 /V1_K /OT_S_HI 180k
R21 B_PLUS B_DRV 3.3k
R22 B_DRV B_V1 150k
C11 B_DRV GND 47u
C12 B_V1 GND 22u
.end
