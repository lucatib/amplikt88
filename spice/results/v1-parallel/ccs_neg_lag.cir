.title KiCad schematic
.include "../../amplikt88.lib"
XV2 LTP_A1 LTP_G1 LTP_K LTP_A2 V2_G2 LTP_K ECC83
C8 LTP_A1 G4_IN 2.2u
C7 LTP_A2 G3_IN 2.2u
R10 V2_G2 LTP_G1 1.8meg
C16 V2_G2 GND 2.2u
C3 IN_RAW IN_C 100n
XV1 V1_A V1_G V1_K LTP_K CCS_G CCS_K ECC83
R2 IN_C GND 470k
R1 IN_C V1_G 1k
R3 B_V1 V1_A 470k
R4 V1_K GND 1.5k
C9 BIAS_A GND 1u
R16 BB_LO GND 27k
R28 BIAS_B VBIAS_NEG 220k
R27 BIAS_A VBIAS_NEG 220k
XRV1 VBIAS_NEG BIAS_A BA_LO POT_TRIM R=10k POS=0.798025513
R15 BA_LO GND 27k
XRV2 VBIAS_NEG BIAS_B BB_LO POT_TRIM R=10k POS=0.798025513
R13 G3_IN V3_G1 5k
XV3 OT_A1 G2_V3 V3_G1 V3_K KT88
XV4 OT_A2 G2_V4 V4_G1 V4_K KT88
R20 V4_K GND 1
R19 V3_K GND 1
R18 G2_V4 OT_UL2 470
R17 G2_V3 OT_UL1 470
R11 G3_IN BIAS_A 200k
R14 G4_IN V4_G1 5k
R12 G4_IN BIAS_B 200k
R6 B_DRV LTP_A1 100k
R7 B_DRV LTP_A2 100k
C10 BIAS_B GND 1u
XTR2 OT_A1 OT_UL1 B_PLUS OT_UL2 OT_A2 OT_S_HI GND OT_PP_UL LH=10 RATIO=22.4
R5 V1_A LTP_G1 1k
C6 V1_K OT_S_HI 12p
R9 V1_K OT_S_HI 180k
R22 B_DRV B_V1 150k
R21 B_PLUS B_DRV 3.3k
C12 B_V1 GND 22u
C11 B_DRV GND 47u

RCCSK CCS_K B_CCS 13k
RCCSF BIAS_RAW B_CCS 2.2k
CCCSF B_CCS GND 100u
RCCS1 GND CCS_G 600k
RCCS2 CCS_G B_CCS 393.24k
CCCS CCS_G GND 10u

RSTEP V1_A NSTEP 15k
CSTEP NSTEP GND 180p

V_BPLUS B_PLUS GND DC 450.0000
VRAW BIAS_SRC GND DC -83.3200
RRAW BIAS_SRC BIAS_RAW 376.7
CB13 BIAS_RAW GND 100u
RB23 BIAS_RAW VBIAS_NEG 2.7k
CB14 VBIAS_NEG GND 100u
VIN IN_RAW GND DC 0 AC 1 SIN(0 {VAMP} 1k)
RL OT_S_HI GND 8
.param VAMP=0
.options reltol=1e-5 abstol=1e-11 vntol=1e-7 itl1=500 itl4=200

.op
.end
